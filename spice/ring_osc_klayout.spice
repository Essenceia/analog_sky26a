* Extracted by KLayout with SKY130 LVS runset on : 10/05/2026 00:37

* cell ring_osc
* pin OUT
* pin VDD
* pin VSS
.SUBCKT ring_osc OUT VDD VSS
* cell instance $1 r0 *1 0,0
X$1 VDD OUT \$I19 VSS inv_cap
* cell instance $2 r0 *1 42,0
X$2 VDD \$I18 OUT VSS inv_cap
* cell instance $6 r0 *1 35,0
X$6 VDD \$I17 \$I18 VSS inv_cap
* cell instance $7 r0 *1 28,0
X$7 VDD \$I16 \$I17 VSS inv_cap
* cell instance $8 r0 *1 21,0
X$8 VDD \$I15 \$I16 VSS inv_cap
* cell instance $9 r0 *1 14,0
X$9 VDD \$I14 \$I15 VSS inv_cap
* cell instance $10 r0 *1 7,0
X$10 VDD \$I19 \$I14 VSS inv_cap
.ENDS ring_osc

* cell inv_cap
* pin VDD
* pin A
* pin X
* pin VSS
.SUBCKT inv_cap VDD A X VSS
* device instance $1 r0 *1 3.27,8.75 sky130_fd_pr__nfet_01v8
XM$1 VSS A X VSS sky130_fd_pr__nfet_01v8 L=1 W=1 AS=0.3 AD=0.3 PS=2.6 PD=2.6
* device instance $2 r0 *1 3.27,12.77 sky130_fd_pr__pfet_01v8
XM$2 VDD A X VDD sky130_fd_pr__pfet_01v8 L=1 W=2 AS=0.6 AD=0.6 PS=4.6 PD=4.6
* device instance $3 r270 *1 3.35,4.78 sky130_fd_pr__model__cap_mim
XC$3 VSS X sky130_fd_pr__model__cap_mim C=6e-14 A=30 P=22
.ENDS inv_cap
