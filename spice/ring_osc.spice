** sch_path: /foss/designs/sym/ring_osc.sch
.subckt ring_osc VDD OUT VSS
*.PININFO VDD:B VSS:B OUT:O
x1 VDD OUT net1 VSS inv_cap
x2 VDD net1 net3 VSS inv_cap
x3 VDD net3 net2 VSS inv_cap
x4 VDD net2 net6 VSS inv_cap
x5 VDD net6 net4 VSS inv_cap
x6 VDD net4 net5 VSS inv_cap
x7 VDD net5 OUT VSS inv_cap
.ends

* expanding   symbol:  /foss/designs/sym/inv_cap.sym # of pins=4
** sym_path: /foss/designs/sym/inv_cap.sym
** sch_path: /foss/designs/sym/inv_cap.sch
.subckt inv_cap VDD A X VSS
*.PININFO A:I X:O VDD:B VSS:B
XM1 X A VDD VDD sky130_fd_pr__pfet_01v8_hvt L=1.0 W=2.0 nf=1
XM2 X A VSS GND sky130_fd_pr__nfet_01v8 L=1 W=1 nf=1
XC1 X VSS sky130_fd_pr__cap_mim_m3_1 W=6 L=5
.ends
